** sch_path: /home/pc/heichips25-ethernet/Vth_test.sch
**.subckt Vth_test
XM3 Vds Vgs GND GND sg13_lv_nmos w=1u l=0.13u ng=1 m=1
Vgs Vgs GND 1.5
Vds Vds GND 1.5
**** begin user architecture code

.param temp=27
.control
save all
op
dc Vgs 0 1.5 0.1
plot v(Vgs)
.endc

 .lib cornerMOSlv.lib mos_tt

**** end user architecture code
**.ends
.GLOBAL GND
.end
