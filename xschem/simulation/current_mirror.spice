** sch_path: /home/pc/heichips25-ethernet/xschem/current_mirror.sch
**.subckt current_mirror
XM3 Vdd Vgs GND GND sg13_lv_nmos w=1u l=0.13u ng=1 m=1
XM4 Vgs Vgs GND GND sg13_lv_nmos w=1u l=0.13u ng=1 m=1
Vsup Vdd GND 1.5
I0 Vdd Vgs 1.5m
**** begin user architecture code
 .lib cornerMOSlv.lib mos_tt

.param temp=27
.control
save all
save @n.xm4.nsg13_lv_nmos[ids]
save @n.xm3.nsg13_lv_nmos[ids]
tran 5n 500n
plot V(Vgs)
plot @n.xm4.nsg13_lv_nmos[ids] @n.xm3.nsg13_lv_nmos[ids]
.endc

**** end user architecture code
**.ends
.GLOBAL GND
.end
