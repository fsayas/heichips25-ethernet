** sch_path: /home/pc/heichips25-ethernet/xschem/mosfet_diode.sch
**.subckt mosfet_diode
XM4 Vgs Vgs GND GND sg13_lv_nmos w=10u l=4u ng=1 m=1
Vdd Vds GND 1.5
XM1 Vds Vds Vgs Vgs sg13_lv_nmos w=10u l=10u ng=1 m=1
XM2 net1 Vgs GND GND sg13_lv_nmos w=50u l=1u ng=5 m=1
R1 Vds net1 100 m=1
**** begin user architecture code

.param temp=27
.control
save all
save @n.xm4.nsg13_lv_nmos[ids]
save @n.xm2.nsg13_lv_nmos[ids]
tran 5n 500n
plot v(Vgs) v(Vds)
plot @n.xm4.nsg13_lv_nmos[ids] @n.xm2.nsg13_lv_nmos[ids]
.endc

 .lib cornerMOSlv.lib mos_tt

**** end user architecture code
**.ends
.GLOBAL GND
.end
